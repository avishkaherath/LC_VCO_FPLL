** sch_path: /foss/designs/uniccass-icdesign-tools/shared_xserver/LC_VCO_FPLL/xschem/BANDGAP_REF.sch
.subckt BANDGAP_REF VDD GND VBGR
*.PININFO VBGR:O GND:B VDD:B
M8 GND v- net1 sub! sg13_lv_nmos w=150n l=10u ng=1
M6 net1 net1 VDD bulk6 sg13_lv_pmos w=1u l=1u ng=1
M7 net2 net1 VDD bulk6 sg13_lv_pmos w=1u l=1u ng=1
M9 v- net2 VDD bulk5 sg13_lv_pmos w=200n l=4u ng=1
M1 v- v+ GND sub! sg13_lv_nmos w=7.14u l=5u ng=4
M2 net3 net3 GND sub! sg13_lv_nmos w=21u l=5u ng=8
M3 v- Vo1 VDD bulk7 sg13_lv_pmos w=15u l=5u ng=8
M4 v+ Vo1 VDD bulk7 sg13_lv_pmos w=15u l=5u ng=8
M5 VBGR Vo1 VDD bulk7 sg13_lv_pmos w=16u l=5u ng=8
R2 VBGR net11 rppd w=0.710e-6 l=38.65e-6 m=1 b=0
C1 net2 GND cap_cmim w=18.2e-6 l=18.2e-6
M10 dn3 v- dn2 bulk sg13_lv_pmos w=3.64u l=3.7u ng=1 m=2
M11 dn4 v+ dn2 bulk sg13_lv_pmos w=3.64u l=3.7u ng=1 m=2
M12 dn4 VDD VDD bulk sg13_lv_pmos w=3.64u l=3.7u ng=1 m=2
M13 dn3 VDD VDD bulk sg13_lv_pmos w=3.64u l=3.7u ng=1 m=2
M15 dn2 VDD VDD bulk sg13_lv_pmos w=3.64u l=3.7u ng=1 m=2
M16 dn2 VDD VDD bulk sg13_lv_pmos w=3.64u l=3.7u ng=1 m=2
R4 VDD bulk ntap1 A=3.309e-11 P=0.0001838
M14 dn2 iout VDD bulk1 sg13_lv_pmos w=5.3u l=1.95u ng=1
R5 GND sub! ptap1 A=2.235e-11 P=6.208e-05
R6 VDD bulk1 ntap1 A=2.043e-11 P=5.674e-05
M17 GND dn3 dn3 sub! sg13_lv_nmos w=720n l=9.75u ng=1
M18 GND dn3 dn4 sub! sg13_lv_nmos w=720n l=9.75u ng=1
M19 Vo1 iout VDD bulk4 sg13_lv_pmos w=75u l=2.08u ng=8
M20 GND dn4 Vo1 sub! sg13_lv_nmos w=28.8u l=9.75u ng=4
M21 iout iout VDD bulk4 sg13_lv_pmos w=75u l=2.08u ng=8
C2 dn4 Vo1 cap_cmim w=22.29e-6 l=22.29e-6
R8 VDD bulk4 ntap1 A=6.526e-11 P=0.0001813
R9 VDD bulk6 ntap1 A=2.099e-11 P=5.83e-05
R12 v+ net7 rppd w=0.5e-6 l=38.65e-6 m=1 b=0
R3 net7 net6 rppd w=0.5e-6 l=38.65e-6 m=1 b=0
R13 net6 net5 rppd w=0.5e-6 l=38.65e-6 m=1 b=0
R14 net5 net4 rppd w=0.5e-6 l=38.65e-6 m=1 b=0
R15 net4 net3 rppd w=0.5e-6 l=38.65e-6 m=1 b=0
R16 net10 net9 rppd w=0.5e-6 l=38.65e-6 m=1 b=0
R17 net9 net8 rppd w=0.5e-6 l=38.65e-6 m=1 b=0
R18 net8 net17 rppd w=0.5e-6 l=38.65e-6 m=1 b=0
R19 net17 GND rppd w=3e-6 l=38.65e-6 m=1 b=0
R20 net11 net12 rppd w=0.710e-6 l=38.65e-6 m=1 b=0
R21 net12 net13 rppd w=0.710e-6 l=38.65e-6 m=1 b=0
R22 net13 net14 rppd w=0.710e-6 l=38.65e-6 m=1 b=0
R23 net14 net15 rppd w=0.710e-6 l=38.65e-6 m=1 b=0
R24 net15 net16 rppd w=0.710e-6 l=38.65e-6 m=1 b=0
R25 net16 GND rppd w=0.710e-6 l=38.65e-6 m=1 b=0
R26 VDD bulk5 ntap1 A=1.29e-11 P=3.584e-05
R27 VDD bulk7 ntap1 A=8.001e-11 P=0.0002222
R7 GND sub! ptap1 A=2.046e-11 P=5.684e-05
R10 GND sub! ptap1 A=7.2e-11 P=0.0002
R11 GND sub! ptap1 A=3.973e-11 P=0.0001104
R28 GND sub! ptap1 A=3.271e-11 P=0.0002044
C3 VDD GND cap_cmim w=5e-6 l=5e-6 m=15
R31 v+ net10 rppd w=0.5e-6 l=38.65e-6 m=1 b=0
R1 iout GND rppd w=0.5e-6 l=15e-6 m=1 b=0
.ends
.GLOBAL VDD
.GLOBAL GND
