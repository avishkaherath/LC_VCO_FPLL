** sch_path: /foss/designs/uniccass-icdesign-tools/shared_xserver/LC_VCO_FPLL/xschem/CHARGE_PUMP.sch
.subckt CHARGE_PUMP UP VDD VCP VBGR GND DN
*.PININFO VCP:O UP:I DN:I GND:B VBGR:B VDD:B
M2 Vbn Vbn net5 bulk2 sg13_lv_nmos w=40.7u l=2u ng=5
M8 net2 GND VDD bulk1 sg13_lv_pmos w=29.6u l=2u ng=5
M11 Vbp Vbp net2 bulk1 sg13_lv_pmos w=163.6u l=2u ng=20
M3 Vbn Vbp net1 bulk1 sg13_lv_pmos w=163.6u l=2u ng=20
M4 net1 GND VDD bulk1 sg13_lv_pmos w=29.6u l=2u ng=5
M7 net3 UP VDD bulk1 sg13_lv_pmos w=29.6u l=2u ng=5
M9 VCP Vbp net3 bulk1 sg13_lv_pmos w=163.6u l=2u ng=20
M10 net5 VDD GND bulk2 sg13_lv_nmos w=6u l=2u ng=1
M1 net4 DN GND bulk2 sg13_lv_nmos w=6u l=2u ng=1
M5 VCP Vbn net4 bulk2 sg13_lv_nmos w=40.7u l=2u ng=5
M6 Vbp VBGR GND bulk2 sg13_lv_nmos w=3.9u l=2u ng=1
R1 VDD bulk1 ntap1 A=4.913e-11 P=0.0003275
R2 VDD bulk1 ntap1 A=3.2e-11 P=0.0002134
R3 GND bulk2 ptap1 A=7.404e-12 P=4.936e-05
R4 GND bulk2 ptap1 A=2.516e-11 P=0.0001678
R5 GND bulk2 ptap1 A=1.524e-11 P=0.0001016
.ends
.GLOBAL GND
.GLOBAL VDD
