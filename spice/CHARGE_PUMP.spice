** sch_path: /home/designer/shared/LC_VCO_FPLL/xschem/CHARGE_PUMP.sch
.subckt CHARGE_PUMP UP VDD VCP VBGR GND DN
*.PININFO VCP:O UP:I DN:I GND:B VBGR:B VDD:B
MM2 Vbn Vbn net5 bulk2 sg13_lv_nmos w=40.7u l=2u ng=5 m=1
MM8 net2 GND VDD bulk1 sg13_lv_pmos w=29.6u l=2u ng=5 m=1
MM11 Vbp Vbp net2 bulk1 sg13_lv_pmos w=163.6u l=2u ng=20 m=1
MM3 Vbn Vbp net1 bulk1 sg13_lv_pmos w=163.6u l=2u ng=20 m=1
MM4 net1 GND VDD bulk1 sg13_lv_pmos w=29.6u l=2u ng=5 m=1
MM7 net3 UP VDD bulk1 sg13_lv_pmos w=29.6u l=2u ng=5 m=1
MM9 VCP Vbp net3 bulk1 sg13_lv_pmos w=163.6u l=2u ng=20 m=1
MM10 net5 VDD GND bulk2 sg13_lv_nmos w=6u l=2u ng=1 m=1
MM1 net4 DN GND bulk2 sg13_lv_nmos w=6u l=2u ng=1 m=1
MM5 VCP Vbn net4 bulk2 sg13_lv_nmos w=40.7u l=2u ng=5 m=1
MM6 Vbp VBGR GND bulk2 sg13_lv_nmos w=3.9u l=2u ng=1 m=1
RR1 VDD bulk1 ntap1 A=5.184e-11 P=0.0003456
RR2 VDD bulk1 ntap1 A=2.724e-11 P=0.0001816
RR3 GND bulk2 ptap1 A=7.404e-12 P=4.936e-05
RR4 GND bulk2 ptap1 A=2.5164e-11 P=0.00016776
RR5 GND bulk2 ptap1 A=1.524e-11 P=0.0001016
.ends
.GLOBAL GND
.GLOBAL VDD
