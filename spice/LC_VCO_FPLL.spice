** sch_path: /foss/designs/uniccass-icdesign-tools/shared_xserver/LC_VCO_FPLL/xschem/LC_VCO_FPLL.sch
**.subckt LC_VCO_FPLL CLK_IN CLK_OUT EN SDATA SCLK RST VDD VSS
*.ipin CLK_IN
*.opin CLK_OUT
*.ipin EN
*.ipin SDATA
*.ipin SCLK
*.ipin RST
*.iopin VDD
*.iopin VSS
x1 CLK_IN UP VDD VSS net1 DN PHASE_FREQ_DET
x2 UP VDD VCP VBGR VSS DN CHARGE_PUMP
x3 VCTRL VCP VSS LOOP_FILTER
x4 VDD VCTRL VSS CLK_OUT VBGR LC_VCO
x5 CLK_OUT RST SCLK SDATA EN net1 VDD VSS DSM_N_FREQ_DIV
**** begin user architecture code

.include DSM_N_FREQ_DIV.spice

**** end user architecture code
**.ends

* expanding   symbol:  xschem/PHASE_FREQ_DET.sym # of pins=6
** sym_path: /foss/designs/uniccass-icdesign-tools/shared_xserver/LC_VCO_FPLL/xschem/PHASE_FREQ_DET.sym
** sch_path: /foss/designs/uniccass-icdesign-tools/shared_xserver/LC_VCO_FPLL/xschem/PHASE_FREQ_DET.sch
.subckt PHASE_FREQ_DET FREF UP VDD GND FDIV DN
*.opin UP
*.ipin FREF
*.iopin VDD
*.iopin GND
*.opin DN
*.ipin FDIV
x1 net1 UP FREF VDD nRST VDD GND sg13g2_dfrbp_2
x2 DN net2 FDIV VDD nRST VDD GND sg13g2_dfrbp_2
x3 nRST net1 DN VDD GND sg13g2_nand2_2
* noconn #net2
.ends

* expanding   symbol:  xschem/CHARGE_PUMP.sym # of pins=6
** sym_path: /foss/designs/uniccass-icdesign-tools/shared_xserver/LC_VCO_FPLL/xschem/CHARGE_PUMP.sym
** sch_path: /foss/designs/uniccass-icdesign-tools/shared_xserver/LC_VCO_FPLL/xschem/CHARGE_PUMP.sch
.subckt CHARGE_PUMP UP VDD VCP VBGR GND DN
*.opin VCP
*.ipin UP
*.ipin DN
*.iopin GND
*.iopin VBGR
*.iopin VDD
XM2 Vbn Vbn net5 GND sg13_lv_nmos w=40.7u l=2u ng=5
XM8 net2 GND VDD VDD sg13_lv_pmos w=29.6u l=2u ng=5
XM11 Vbp Vbp net2 VDD sg13_lv_pmos w=163.6u l=2u ng=20
XM3 Vbn Vbp net1 VDD sg13_lv_pmos w=163.6u l=2u ng=20
XM4 net1 GND VDD VDD sg13_lv_pmos w=29.6u l=2u ng=5
XM7 net3 UP VDD VDD sg13_lv_pmos w=29.6u l=2u ng=5
XM9 VCP Vbp net3 VDD sg13_lv_pmos w=163.6u l=2u ng=20
XM10 net5 VDD GND GND sg13_lv_nmos w=6u l=2u ng=1
XM1 net4 DN GND GND sg13_lv_nmos w=6u l=2u ng=1
XM5 VCP Vbn net4 GND sg13_lv_nmos w=40.7u l=2u ng=5
XM6 Vbp VBGR GND GND sg13_lv_nmos w=3.9u l=2u ng=1
.ends

* expanding   symbol:  xschem/LOOP_FILTER.sym # of pins=3
** sym_path: /foss/designs/uniccass-icdesign-tools/shared_xserver/LC_VCO_FPLL/xschem/LOOP_FILTER.sym
** sch_path: /foss/designs/uniccass-icdesign-tools/shared_xserver/LC_VCO_FPLL/xschem/LOOP_FILTER.sch
.subckt LOOP_FILTER OUT IN GND
*.opin OUT
*.iopin GND
*.ipin IN
XC2 OUT GND cap_cmim w=18.63e-6 l=18.63e-6 m=4
XC1 net1 GND cap_cmim w=48.34e-6 l=48.34e-6 m=16
XR2 OUT IN sub! rppd w=2e-6 l=407.22e-6 m=1 b=0
XR1 net1 IN sub! rppd w=2e-6 l=407.22e-6 m=1 b=0
.ends

* expanding   symbol:  xschem/LC_VCO.sym # of pins=5
** sym_path: /foss/designs/uniccass-icdesign-tools/shared_xserver/LC_VCO_FPLL/xschem/LC_VCO.sym
** sch_path: /foss/designs/uniccass-icdesign-tools/shared_xserver/LC_VCO_FPLL/xschem/LC_VCO.sch
.subckt LC_VCO VDD VCTRL GND FOUT VBGR
*.opin FOUT
*.ipin VCTRL
*.ipin VBGR
*.iopin VDD
*.iopin GND
XM5 Vx Vgs GND GND sg13_lv_nmos w=384u l=1u ng=48
XM4 OUTp OUTn VDD VDD sg13_lv_pmos w=36u l=0.13u ng=5
XM3 OUTn OUTp VDD VDD sg13_lv_pmos w=36u l=0.13u ng=5
XM2 OUTp OUTn Vx GND sg13_lv_nmos w=22u l=0.13u ng=3
XM1 OUTn OUTp Vx GND sg13_lv_nmos w=22u l=0.13u ng=3
XM6 Vgs Vgs GND GND sg13_lv_nmos w=64u l=1u ng=8
XC1 OUTn OUTp GND cap_rfcmim w=21.9e-6 l=21.9e-6 wfeed=10.0e-6
XC3 OUTp VCTRL OUTn GND sg13_hv_svaricap w=9.74u l=0.8u Nx=7
XC2 OUTp VCTRL OUTn GND sg13_hv_svaricap w=9.74u l=0.8u Nx=7
XM7 Vgs VBGR VDD VDD sg13_lv_pmos w=38u l=1u ng=5
XM8 FOUT OUTp VDD VDD sg13_lv_pmos w=15u l=0.13u ng=10
XM9 FOUT OUTp GND GND sg13_lv_nmos w=1.5u l=0.13u ng=1
XM10 net1 OUTn VDD VDD sg13_lv_pmos w=15u l=0.13u ng=10
XM11 net1 OUTn GND GND sg13_lv_nmos w=1.5u l=0.13u ng=1
x1 OUTn OUTp 4nH_INDUCTOR
**** begin user architecture code

.include 4nH_INDUCTOR.spice

**** end user architecture code
.ends

.GLOBAL VSS
.GLOBAL VDD
.GLOBAL GND
.end
