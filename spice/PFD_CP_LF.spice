** sch_path: /foss/designs/uniccass-icdesign-tools/shared_xserver/LC_VCO_FPLL/xschem/PFD_CP_LF.sch
.subckt PFD_CP_LF CLK_IN VCTRL VDD VSS CLK_FB VBGR
*.PININFO CLK_IN:I VCTRL:O VDD:B VSS:B CLK_FB:I VBGR:B
x1 CLK_IN UP VDD VSS CLK_FB DN PHASE_FREQ_DET
x2 UP VDD VCP VBGR VSS DN CHARGE_PUMP
x3 VCTRL VCP VSS LOOP_FILTER
.ends

* expanding   symbol:  xschem/PHASE_FREQ_DET.sym # of pins=6
** sym_path: /foss/designs/uniccass-icdesign-tools/shared_xserver/LC_VCO_FPLL/xschem/PHASE_FREQ_DET.sym
** sch_path: /foss/designs/uniccass-icdesign-tools/shared_xserver/LC_VCO_FPLL/xschem/PHASE_FREQ_DET.sch
.subckt PHASE_FREQ_DET FREF UP VDD GND FDIV DN
*.PININFO UP:O FREF:I VDD:B GND:B DN:O FDIV:I
x1 net1 UP FREF VDD nRST VDD GND sg13g2_dfrbp_2
x2 DN net2 FDIV VDD nRST VDD GND sg13g2_dfrbp_2
x3 nRST net1 DN VDD GND sg13g2_nand2_2
* noconn #net2
.ends

* expanding   symbol:  xschem/CHARGE_PUMP.sym # of pins=6
** sym_path: /foss/designs/uniccass-icdesign-tools/shared_xserver/LC_VCO_FPLL/xschem/CHARGE_PUMP.sym
** sch_path: /foss/designs/uniccass-icdesign-tools/shared_xserver/LC_VCO_FPLL/xschem/CHARGE_PUMP.sch
.subckt CHARGE_PUMP UP VDD VCP VBGR GND DN
*.PININFO VCP:O UP:I DN:I GND:B VBGR:B VDD:B
M2 Vbn Vbn net5 bulk2 sg13_lv_nmos w=40.7u l=2u ng=5
M8 net2 GND VDD bulk1 sg13_lv_pmos w=29.6u l=2u ng=5
M11 Vbp Vbp net2 bulk1 sg13_lv_pmos w=163.6u l=2u ng=20
M3 Vbn Vbp net1 bulk1 sg13_lv_pmos w=163.6u l=2u ng=20
M4 net1 GND VDD bulk1 sg13_lv_pmos w=29.6u l=2u ng=5
M7 net3 UP VDD bulk1 sg13_lv_pmos w=29.6u l=2u ng=5
M9 VCP Vbp net3 bulk1 sg13_lv_pmos w=163.6u l=2u ng=20
M10 net5 VDD GND bulk2 sg13_lv_nmos w=6u l=2u ng=1
M1 net4 DN GND bulk2 sg13_lv_nmos w=6u l=2u ng=1
M5 VCP Vbn net4 bulk2 sg13_lv_nmos w=40.7u l=2u ng=5
M6 Vbp VBGR GND bulk2 sg13_lv_nmos w=3.9u l=2u ng=1
R1 VDD bulk1 ntap1 A=5.184e-11 P=0.0003456
R2 VDD bulk1 ntap1 A=2.724e-11 P=0.0001816
R3 GND bulk2 ptap1 A=7.404e-12 P=4.936e-05
R4 GND bulk2 ptap1 A=2.516e-11 P=0.0001678
R5 GND bulk2 ptap1 A=1.524e-11 P=0.0001016
.ends

* expanding   symbol:  xschem/LOOP_FILTER.sym # of pins=3
** sym_path: /foss/designs/uniccass-icdesign-tools/shared_xserver/LC_VCO_FPLL/xschem/LOOP_FILTER.sym
** sch_path: /foss/designs/uniccass-icdesign-tools/shared_xserver/LC_VCO_FPLL/xschem/LOOP_FILTER.sch
.subckt LOOP_FILTER OUT IN GND
*.PININFO OUT:O GND:B IN:I
C2 OUT GND cap_cmim w=18.63e-6 l=18.63e-6 m=4
C1 net1 GND cap_cmim w=48.34e-6 l=48.34e-6 m=16
R2 OUT IN rppd w=2e-6 l=407.2e-6 m=1 b=0
R1 net1 IN rppd w=2e-6 l=407.2e-6 m=1 b=0
R3 GND sub! ptap1 A=4.675e-11 P=0.0003117
R4 GND sub! ptap1 A=4.675e-11 P=0.0003117
.ends

.GLOBAL VSS
.GLOBAL VDD
.GLOBAL GND
